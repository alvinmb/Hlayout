.title KiCad schematic
.include "GDZ16B.lib"
.include "LM3886.lib"
.include "Loudspeaker.lib"
.include "Tian_subckt.lib"
C1 Net-_C1-Pad1_ IN 4.7u
R2 Net-_C2-Pad1_ Net-_C1-Pad1_ 1k
V1 IN GND dc 0 ac 0 sin(0 1 1k)
R3 Net-_C4-Pad2_ Net-_C3-Pad1_ 1k
C3 Net-_C3-Pad1_ GND 470u
C2 Net-_C2-Pad1_ GND 680p
VN1 V- GND dc -30
R1 Net-_C1-Pad1_ GND 20k
VP1 V+ GND dc 30
X999 Net-_L1-Pad1_ Net-_R4-Pad2_ loopgainprobe
XU1 Net-_C2-Pad1_ Net-_C4-Pad2_ V+ V- Net-_L1-Pad1_ /m2 lm3886
R5 Net-_C4-Pad1_ Net-_R4-Pad2_ 20k
C4 Net-_C4-Pad1_ Net-_C4-Pad2_ 50p
R4 Net-_C4-Pad2_ Net-_R4-Pad2_ 20k
R7 Net-_L1-Pad1_ Net-_C6-Pad1_ 4.7
C6 Net-_C6-Pad1_ GND 20n
XLS1 OUT GND DC50FA8
D1 /m1 /m2 GDZ16B
L1 Net-_L1-Pad1_ OUT 0.7u
R8 Net-_L1-Pad1_ OUT 10
C5 /m1 GND 68u
R6 /m1 V- 10k
.tran 10u 1200m
.ic v(/m1)=0
.end
